* ESC FOC AUTO-GENERATED SPICE NETLIST

CC24 Net__U4_IN__ 0 1e-09
RR18 Net__U4_IN__ _current_sensing_W 10.0
CC29 Net__U4_IN__ Net__U4_IN__ 1e-08
CC8 0 _BATT 2.2e-05
CC31 0 N3V3 9.999999999999999e-06
CC26 0 N3V3 1e-07
CC34 0 _BATT 2.2e-05
CC32 0 _BATT 2.2e-05
CC25 0 _current_sensing_1_65V 1.0000000000000001e-07
CC3 0 N3V3 1e-07
CC9 0 _BATT 2.2e-05
CC2 0 N5V 9.999999999999999e-06
CC16 0 N3V3 1e-07
CC17 0 N3V3 1e-07
CC5 0 _BATT 2.2e-05
CC19 0 N3V3 1e-07
CC13 0 _BATT 0.00047
CC28 0 N3V3 1.0000000000000001e-07
CC35 0 Net__U2_PG10_ 1e-07
CC1 0 _BATT 0.00047
CC15 0 N5V 9.999999999999999e-05
CC33 0 _BATT 2.2e-05
CC30 0 Net__U4_IN__ 1e-09
RR21 0 Net__U2_PB8_ 10000.0
CC27 0 N3V3 1e-06
CC23 0 Net__U1_IN__ 1e-09
CC14 0 _BATT 1e-07
CC7 0 _BATT 1e-07
CC37 0 Net__U2_PA7_ 2.2000000000000003e-09
CC20 0 _current_sensing_1_65V 1.0000000000000001e-07
RR6 0 Net__U6A___ 10000.0
CC10 0 N12V 9.999999999999999e-05
CC36 0 Net__U2_PA1_ 2.2000000000000003e-09
CC21 0 N3V3 1.0000000000000001e-07
CC4 0 N12V 1e-07
CC18 0 Net__U1_IN__ 1e-09
RR2 Net__Q3_G_ HO1 10.0
RR14 _current_sensing_U Net__U1_IN__ 10.0
CC6 _current_sensing_U Net__D2_K_ 1e-06
CC11 _inverter_V Net__D3_K_ 1e-06
RR5 N3V3 Net__U6A___ 10000.0
RR8 Net__Q7_G_ HO2 10.0
CC12 _current_sensing_W Net__D4_K_ 1e-06
RR20 _current_sensing_Tw Net__U4_IN__ 10.0
RR12 Net__Q11_G_ HO3 10.0
RR4 Net__Q4_G_ LO1 10.0
RR17 _current_sensing_Tu Net__U1_IN__ 10.0
RR15 Net__Q12_G_ LO3 10.0
RR19 ADC2 Net__U2_PA7_ 100.0
RR16 Net__U2_PA1_ ADC1 100.0
CC22 Net__U1_IN__ Net__U1_IN__ 1e-08
RR10 Net__Q8_G_ LO2 10.0
RR13 LO3 Net__Q10_G_ 10.0
RR9 LO2 Net__Q6_G_ 10.0
RR3 LO1 Net__Q2_G_ 10.0
RR11 HO3 Net__Q9_G_ 10.0
RR7 HO2 Net__Q5_G_ 10.0
RR1 HO1 Net__Q1_G_ 10.0

* === MOSFETs ===

* === Power Rails (Simplified for .op) ===
V_BATT +BATT 0 DC 25.2
V_12V 12V 0 DC 12.0
V_5V 5V 0 DC 5.0
V_3V3 3V3 0 DC 3.3
R_LOAD_MCU 3V3 0 50
R_LOAD_GATE 12V 0 100

* === Gate Drives (Solver will override) ===

* === Motor Load (Solver will override) ===
I_MOTOR_U_V PHASE_U PHASE_V DC 0

.model AOD4184A NMOS(Vto=2.0 Kp=50 Cgdmax=1n Cgdmin=10p Cgs=2n Cjo=1n Is=1e-15 Rb=3m)
.op
.end
